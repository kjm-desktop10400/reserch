; ------------------------------------------------------------------------------
; Batch loader for PCELLs
; Written by Keisuke Kawahara <7320529@ed.tus.ac.jp>
; ------------------------------------------------------------------------------

load("./PCELL/IND_OCT.il")
load("./PCELL/IND_SQ.il")
load("./PCELL/TLINE_DIFF.il")
load("./PCELL/TLINE.il")
load("./PCELL/TRANS_TLT.il")
load("./PCELL/VIA_ARRAY.il")
