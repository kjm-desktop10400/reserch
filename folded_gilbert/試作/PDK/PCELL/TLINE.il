pcDefinePCell(list(ddGetObj("ROHMLIB") "TLINE" "layout")
    ((Length float 1.0)
	(Width float 8.0)
    )
    let((Length Length0 Length0offset Width Width1
	    Width1offset pcMember pcStretchGroup stretchOffsetX stretchOffsetY
	    pcLib pcMaster pcInst pcTerm pcPin
	    pcPinName pcNet pcTermNet pcNetName pcTermNetName
	    pcMosaicInst pcParameters pcParamProp pcStep pcStepX
	    pcStepY pcRepeat pcRepeatX pcRepeatY pcIndexX
	    pcIndexY pcLayer pcPurpose pcLabelText pcLabelHeight
	    pcPropText pcParamText pcCoords pcPathWidth pcPolygonMargin
	)
	(pcLib = (pcCellView~>lib))
	(pcParameters = ((pcCellView~>parameters)~>value))
	(pcParamProp = car(exists(prop pcParameters
		    ((prop~>name) == "Length")
		)
	    ))
	(Length = (pcParamProp~>value))
	if(((pcParamProp~>valueType) == "boolean")
	    (Length = (Length == "TRUE"))
	)
	(pcParamProp = car(exists(prop pcParameters
		    ((prop~>name) == "Width")
		)
	    ))
	(Width = (pcParamProp~>value))
	if(((pcParamProp~>valueType) == "boolean")
	    (Width = (Width == "TRUE"))
	)
	(Length0 = Length)
	(Width1 = Width)
	if((Length0 < 1) then
	    (Length0 = 1.0)
	)
	(Length0offset = (Length0 - 1))
	if((Width1 < 1) then
	    (Width1 = 1.0)
	)
	if((Width1 > 24) then
	    (Width1 = 24.0)
	)
	(Width1offset = ((Width1 - 8) / 2))
	dbReplaceProp(pcCellView "_pcCompiledCounter" "int" 2391)
	dbReplaceProp(pcCellView "viewSubType" "string" "maskLayoutParamCell")
	(pcRepeat = (pcRepeatX = (pcRepeatY = 1.0)))
	(pcStep = (pcStepX = (pcStepY = 0.0)))
	(pcStep = (pcStepX = car(errset(0.72))))
	(pcRepeat = (pcRepeatX = fix(((Length - 0.32) / pcStep))))
	(pcStep = (pcStepX = 0.72))
	(pcIndexY = 0)
	for(pcIndexX 0
	    (fix(pcRepeatX) - 1) nil
	    (pcLayer = 11)
	    (pcPurpose = "drawing")
	    (pcInst = dbCreateRect(pcCellView
		    list(pcLayer pcPurpose)
		    list(((0.36 + (pcIndexX * pcStepX)):(15.48 + Width1offset - Width1offset))
			((0.64 + (pcIndexX * pcStepX)):(15.76 + Width1offset - Width1offset))
		    )
		))
	    (pcLayer = 11)
	    (pcPurpose = "drawing")
	    (pcInst = dbCreateRect(pcCellView
		    list(pcLayer pcPurpose)
		    list(((0.36 + (pcIndexX * pcStepX)):(16.2 + Width1offset - Width1offset))
			((0.64 + (pcIndexX * pcStepX)):(16.48 + Width1offset - Width1offset))
		    )
		))
	    (pcLayer = 11)
	    (pcPurpose = "drawing")
	    (pcInst = dbCreateRect(pcCellView
		    list(pcLayer pcPurpose)
		    list(((0.36 + (pcIndexX * pcStepX)):(16.92 + Width1offset - Width1offset))
			((0.64 + (pcIndexX * pcStepX)):(17.2 + Width1offset - Width1offset))
		    )
		))
	    (pcLayer = 11)
	    (pcPurpose = "drawing")
	    (pcInst = dbCreateRect(pcCellView
		    list(pcLayer pcPurpose)
		    list(((0.36 + (pcIndexX * pcStepX)):(17.64 + Width1offset - Width1offset))
			((0.64 + (pcIndexX * pcStepX)):(17.92 + Width1offset - Width1offset))
		    )
		))
	    (pcLayer = 11)
	    (pcPurpose = "drawing")
	    (pcInst = dbCreateRect(pcCellView
		    list(pcLayer pcPurpose)
		    list(((0.36 + (pcIndexX * pcStepX)):(18.36 + Width1offset - Width1offset))
			((0.64 + (pcIndexX * pcStepX)):(18.64 + Width1offset - Width1offset))
		    )
		))
	    (pcLayer = 11)
	    (pcPurpose = "drawing")
	    (pcInst = dbCreateRect(pcCellView
		    list(pcLayer pcPurpose)
		    list(((0.36 + (pcIndexX * pcStepX)):(19.08 + Width1offset - Width1offset))
			((0.64 + (pcIndexX * pcStepX)):(19.36 + Width1offset - Width1offset))
		    )
		))
	    (pcLayer = 11)
	    (pcPurpose = "drawing")
	    (pcInst = dbCreateRect(pcCellView
		    list(pcLayer pcPurpose)
		    list(((0.36 + (pcIndexX * pcStepX)):(19.8 + Width1offset - Width1offset))
			((0.64 + (pcIndexX * pcStepX)):(20.08 + Width1offset - Width1offset))
		    )
		))
	    (pcLayer = 13)
	    (pcPurpose = "drawing")
	    (pcInst = dbCreateRect(pcCellView
		    list(pcLayer pcPurpose)
		    list(((0.36 + (pcIndexX * pcStepX)):(15.48 + Width1offset - Width1offset))
			((0.64 + (pcIndexX * pcStepX)):(15.76 + Width1offset - Width1offset))
		    )
		))
	    (pcLayer = 13)
	    (pcPurpose = "drawing")
	    (pcInst = dbCreateRect(pcCellView
		    list(pcLayer pcPurpose)
		    list(((0.36 + (pcIndexX * pcStepX)):(16.2 + Width1offset - Width1offset))
			((0.64 + (pcIndexX * pcStepX)):(16.48 + Width1offset - Width1offset))
		    )
		))
	    (pcLayer = 13)
	    (pcPurpose = "drawing")
	    (pcInst = dbCreateRect(pcCellView
		    list(pcLayer pcPurpose)
		    list(((0.36 + (pcIndexX * pcStepX)):(16.92 + Width1offset - Width1offset))
			((0.64 + (pcIndexX * pcStepX)):(17.2 + Width1offset - Width1offset))
		    )
		))
	    (pcLayer = 13)
	    (pcPurpose = "drawing")
	    (pcInst = dbCreateRect(pcCellView
		    list(pcLayer pcPurpose)
		    list(((0.36 + (pcIndexX * pcStepX)):(17.64 + Width1offset - Width1offset))
			((0.64 + (pcIndexX * pcStepX)):(17.92 + Width1offset - Width1offset))
		    )
		))
	    (pcLayer = 13)
	    (pcPurpose = "drawing")
	    (pcInst = dbCreateRect(pcCellView
		    list(pcLayer pcPurpose)
		    list(((0.36 + (pcIndexX * pcStepX)):(18.36 + Width1offset - Width1offset))
			((0.64 + (pcIndexX * pcStepX)):(18.64 + Width1offset - Width1offset))
		    )
		))
	    (pcLayer = 13)
	    (pcPurpose = "drawing")
	    (pcInst = dbCreateRect(pcCellView
		    list(pcLayer pcPurpose)
		    list(((0.36 + (pcIndexX * pcStepX)):(19.08 + Width1offset - Width1offset))
			((0.64 + (pcIndexX * pcStepX)):(19.36 + Width1offset - Width1offset))
		    )
		))
	    (pcLayer = 13)
	    (pcPurpose = "drawing")
	    (pcInst = dbCreateRect(pcCellView
		    list(pcLayer pcPurpose)
		    list(((0.36 + (pcIndexX * pcStepX)):(19.8 + Width1offset - Width1offset))
			((0.64 + (pcIndexX * pcStepX)):(20.08 + Width1offset - Width1offset))
		    )
		))
	    (pcLayer = 15)
	    (pcPurpose = "drawing")
	    (pcInst = dbCreateRect(pcCellView
		    list(pcLayer pcPurpose)
		    list(((0.36 + (pcIndexX * pcStepX)):(15.48 + Width1offset - Width1offset))
			((0.64 + (pcIndexX * pcStepX)):(15.76 + Width1offset - Width1offset))
		    )
		))
	    (pcLayer = 15)
	    (pcPurpose = "drawing")
	    (pcInst = dbCreateRect(pcCellView
		    list(pcLayer pcPurpose)
		    list(((0.36 + (pcIndexX * pcStepX)):(16.2 + Width1offset - Width1offset))
			((0.64 + (pcIndexX * pcStepX)):(16.48 + Width1offset - Width1offset))
		    )
		))
	    (pcLayer = 15)
	    (pcPurpose = "drawing")
	    (pcInst = dbCreateRect(pcCellView
		    list(pcLayer pcPurpose)
		    list(((0.36 + (pcIndexX * pcStepX)):(16.92 + Width1offset - Width1offset))
			((0.64 + (pcIndexX * pcStepX)):(17.2 + Width1offset - Width1offset))
		    )
		))
	    (pcLayer = 15)
	    (pcPurpose = "drawing")
	    (pcInst = dbCreateRect(pcCellView
		    list(pcLayer pcPurpose)
		    list(((0.36 + (pcIndexX * pcStepX)):(17.64 + Width1offset - Width1offset))
			((0.64 + (pcIndexX * pcStepX)):(17.92 + Width1offset - Width1offset))
		    )
		))
	    (pcLayer = 15)
	    (pcPurpose = "drawing")
	    (pcInst = dbCreateRect(pcCellView
		    list(pcLayer pcPurpose)
		    list(((0.36 + (pcIndexX * pcStepX)):(18.36 + Width1offset - Width1offset))
			((0.64 + (pcIndexX * pcStepX)):(18.64 + Width1offset - Width1offset))
		    )
		))
	    (pcLayer = 15)
	    (pcPurpose = "drawing")
	    (pcInst = dbCreateRect(pcCellView
		    list(pcLayer pcPurpose)
		    list(((0.36 + (pcIndexX * pcStepX)):(19.08 + Width1offset - Width1offset))
			((0.64 + (pcIndexX * pcStepX)):(19.36 + Width1offset - Width1offset))
		    )
		))
	    (pcLayer = 15)
	    (pcPurpose = "drawing")
	    (pcInst = dbCreateRect(pcCellView
		    list(pcLayer pcPurpose)
		    list(((0.36 + (pcIndexX * pcStepX)):(19.8 + Width1offset - Width1offset))
			((0.64 + (pcIndexX * pcStepX)):(20.08 + Width1offset - Width1offset))
		    )
		))
	    (pcLayer = 17)
	    (pcPurpose = "drawing")
	    (pcInst = dbCreateRect(pcCellView
		    list(pcLayer pcPurpose)
		    list(((0.32 + (pcIndexX * pcStepX)):(15.44 + Width1offset - Width1offset))
			((0.68 + (pcIndexX * pcStepX)):(15.8 + Width1offset - Width1offset))
		    )
		))
	    (pcLayer = 17)
	    (pcPurpose = "drawing")
	    (pcInst = dbCreateRect(pcCellView
		    list(pcLayer pcPurpose)
		    list(((0.32 + (pcIndexX * pcStepX)):(16.16 + Width1offset - Width1offset))
			((0.68 + (pcIndexX * pcStepX)):(16.52 + Width1offset - Width1offset))
		    )
		))
	    (pcLayer = 17)
	    (pcPurpose = "drawing")
	    (pcInst = dbCreateRect(pcCellView
		    list(pcLayer pcPurpose)
		    list(((0.32 + (pcIndexX * pcStepX)):(16.88 + Width1offset - Width1offset))
			((0.68 + (pcIndexX * pcStepX)):(17.24 + Width1offset - Width1offset))
		    )
		))
	    (pcLayer = 17)
	    (pcPurpose = "drawing")
	    (pcInst = dbCreateRect(pcCellView
		    list(pcLayer pcPurpose)
		    list(((0.32 + (pcIndexX * pcStepX)):(17.6 + Width1offset - Width1offset))
			((0.68 + (pcIndexX * pcStepX)):(17.96 + Width1offset - Width1offset))
		    )
		))
	    (pcLayer = 17)
	    (pcPurpose = "drawing")
	    (pcInst = dbCreateRect(pcCellView
		    list(pcLayer pcPurpose)
		    list(((0.32 + (pcIndexX * pcStepX)):(18.32 + Width1offset) - Width1offset)
			((0.68 + (pcIndexX * pcStepX)):(18.68 + Width1offset - Width1offset))
		    )
		))
	    (pcLayer = 17)
	    (pcPurpose = "drawing")
	    (pcInst = dbCreateRect(pcCellView
		    list(pcLayer pcPurpose)
		    list(((0.32 + (pcIndexX * pcStepX)):(19.04 + Width1offset - Width1offset))
			((0.68 + (pcIndexX * pcStepX)):(19.4 + Width1offset - Width1offset))
		    )
		))
	    (pcLayer = 17)
	    (pcPurpose = "drawing")
	    (pcInst = dbCreateRect(pcCellView
		    list(pcLayer pcPurpose)
		    list(((0.32 + (pcIndexX * pcStepX)):(19.76 + Width1offset - Width1offset))
			((0.68 + (pcIndexX * pcStepX)):(20.12 + Width1offset - Width1offset))
		    )
		))
	    (pcLayer = 11)
	    (pcPurpose = "drawing")
	    (pcInst = dbCreateRect(pcCellView
		    list(pcLayer pcPurpose)
		    list(((0.36 + (pcIndexX * pcStepX)):(14.76 + Width1offset - Width1offset))
			((0.64 + (pcIndexX * pcStepX)):(15.04 + Width1offset - Width1offset))
		    )
		))
	    (pcLayer = 13)
	    (pcPurpose = "drawing")
	    (pcInst = dbCreateRect(pcCellView
		    list(pcLayer pcPurpose)
		    list(((0.36 + (pcIndexX * pcStepX)):(14.76 + Width1offset - Width1offset))
			((0.64 + (pcIndexX * pcStepX)):(15.04 + Width1offset - Width1offset))
		    )
		))
	    (pcLayer = 15)
	    (pcPurpose = "drawing")
	    (pcInst = dbCreateRect(pcCellView
		    list(pcLayer pcPurpose)
		    list(((0.36 + (pcIndexX * pcStepX)):(14.76 + Width1offset - Width1offset))
			((0.64 + (pcIndexX * pcStepX)):(15.04 + Width1offset - Width1offset))
		    )
		))
	    (pcLayer = 17)
	    (pcPurpose = "drawing")
	    (pcInst = dbCreateRect(pcCellView
		    list(pcLayer pcPurpose)
		    list(((0.32 + (pcIndexX * pcStepX)):(14.72 + Width1offset - Width1offset))
			((0.68 + (pcIndexX * pcStepX)):(15.08 + Width1offset - Width1offset))
		    )
		))
	)
	(pcRepeat = (pcRepeatX = (pcRepeatY = 1.0)))
	(pcStep = (pcStepX = (pcStepY = 0.0)))
	(pcStep = (pcStepX = car(errset(0.72))))
	(pcRepeat = (pcRepeatX = fix(((Length - 0.32) / pcStep))))
	(pcStep = (pcStepX = 0.72))
	(pcIndexY = 0)
	for(pcIndexX 0
	    (fix(pcRepeatX) - 1) nil
	    (pcLayer = 11)
	    (pcPurpose = "drawing")
	    (pcInst = dbCreateRect(pcCellView
		    list(pcLayer pcPurpose)
		    list(((0.36 + (pcIndexX * pcStepX)):(-20.08 - Width1offset + Width1offset))
			((0.64 + (pcIndexX * pcStepX)):(-19.8 - Width1offset + Width1offset))
		    )
		))
	    (pcLayer = 11)
	    (pcPurpose = "drawing")
	    (pcInst = dbCreateRect(pcCellView
		    list(pcLayer pcPurpose)
		    list(((0.36 + (pcIndexX * pcStepX)):(-19.36 - Width1offset + Width1offset))
			((0.64 + (pcIndexX * pcStepX)):(-19.08 - Width1offset + Width1offset))
		    )
		))
	    (pcLayer = 11)
	    (pcPurpose = "drawing")
	    (pcInst = dbCreateRect(pcCellView
		    list(pcLayer pcPurpose)
		    list(((0.36 + (pcIndexX * pcStepX)):(-18.64 - Width1offset + Width1offset))
			((0.64 + (pcIndexX * pcStepX)):(-18.36 - Width1offset + Width1offset))
		    )
		))
	    (pcLayer = 11)
	    (pcPurpose = "drawing")
	    (pcInst = dbCreateRect(pcCellView
		    list(pcLayer pcPurpose)
		    list(((0.36 + (pcIndexX * pcStepX)):(-17.92 - Width1offset + Width1offset))
			((0.64 + (pcIndexX * pcStepX)):(-17.64 - Width1offset + Width1offset))
		    )
		))
	    (pcLayer = 11)
	    (pcPurpose = "drawing")
	    (pcInst = dbCreateRect(pcCellView
		    list(pcLayer pcPurpose)
		    list(((0.36 + (pcIndexX * pcStepX)):(-17.2 - Width1offset + Width1offset))
			((0.64 + (pcIndexX * pcStepX)):(-16.92 - Width1offset + Width1offset))
		    )
		))
	    (pcLayer = 11)
	    (pcPurpose = "drawing")
	    (pcInst = dbCreateRect(pcCellView
		    list(pcLayer pcPurpose)
		    list(((0.36 + (pcIndexX * pcStepX)):(-16.48 - Width1offset + Width1offset))
			((0.64 + (pcIndexX * pcStepX)):(-16.2 - Width1offset + Width1offset))
		    )
		))
	    (pcLayer = 11)
	    (pcPurpose = "drawing")
	    (pcInst = dbCreateRect(pcCellView
		    list(pcLayer pcPurpose)
		    list(((0.36 + (pcIndexX * pcStepX)):(-15.76 - Width1offset + Width1offset))
			((0.64 + (pcIndexX * pcStepX)):(-15.48 - Width1offset + Width1offset))
		    )
		))
	    (pcLayer = 11)
	    (pcPurpose = "drawing")
	    (pcInst = dbCreateRect(pcCellView
		    list(pcLayer pcPurpose)
		    list(((0.36 + (pcIndexX * pcStepX)):(-15.04 - Width1offset + Width1offset))
			((0.64 + (pcIndexX * pcStepX)):(-14.76 - Width1offset + Width1offset))
		    )
		))
	    (pcLayer = 13)
	    (pcPurpose = "drawing")
	    (pcInst = dbCreateRect(pcCellView
		    list(pcLayer pcPurpose)
		    list(((0.36 + (pcIndexX * pcStepX)):(-20.08 - Width1offset + Width1offset))
			((0.64 + (pcIndexX * pcStepX)):(-19.8 - Width1offset + Width1offset))
		    )
		))
	    (pcLayer = 13)
	    (pcPurpose = "drawing")
	    (pcInst = dbCreateRect(pcCellView
		    list(pcLayer pcPurpose)
		    list(((0.36 + (pcIndexX * pcStepX)):(-19.36 - Width1offset + Width1offset))
			((0.64 + (pcIndexX * pcStepX)):(-19.08 - Width1offset + Width1offset))
		    )
		))
	    (pcLayer = 13)
	    (pcPurpose = "drawing")
	    (pcInst = dbCreateRect(pcCellView
		    list(pcLayer pcPurpose)
		    list(((0.36 + (pcIndexX * pcStepX)):(-18.64 - Width1offset + Width1offset))
			((0.64 + (pcIndexX * pcStepX)):(-18.36 - Width1offset + Width1offset))
		    )
		))
	    (pcLayer = 13)
	    (pcPurpose = "drawing")
	    (pcInst = dbCreateRect(pcCellView
		    list(pcLayer pcPurpose)
		    list(((0.36 + (pcIndexX * pcStepX)):(-17.92 - Width1offset + Width1offset))
			((0.64 + (pcIndexX * pcStepX)):(-17.64 - Width1offset + Width1offset))
		    )
		))
	    (pcLayer = 13)
	    (pcPurpose = "drawing")
	    (pcInst = dbCreateRect(pcCellView
		    list(pcLayer pcPurpose)
		    list(((0.36 + (pcIndexX * pcStepX)):(-17.2 - Width1offset + Width1offset))
			((0.64 + (pcIndexX * pcStepX)):(-16.92 - Width1offset + Width1offset))
		    )
		))
	    (pcLayer = 13)
	    (pcPurpose = "drawing")
	    (pcInst = dbCreateRect(pcCellView
		    list(pcLayer pcPurpose)
		    list(((0.36 + (pcIndexX * pcStepX)):(-16.48 - Width1offset + Width1offset))
			((0.64 + (pcIndexX * pcStepX)):(-16.2 - Width1offset + Width1offset))
		    )
		))
	    (pcLayer = 13)
	    (pcPurpose = "drawing")
	    (pcInst = dbCreateRect(pcCellView
		    list(pcLayer pcPurpose)
		    list(((0.36 + (pcIndexX * pcStepX)):(-15.76 - Width1offset + Width1offset))
			((0.64 + (pcIndexX * pcStepX)):(-15.48 - Width1offset + Width1offset))
		    )
		))
	    (pcLayer = 13)
	    (pcPurpose = "drawing")
	    (pcInst = dbCreateRect(pcCellView
		    list(pcLayer pcPurpose)
		    list(((0.36 + (pcIndexX * pcStepX)):(-15.04 - Width1offset + Width1offset))
			((0.64 + (pcIndexX * pcStepX)):(-14.76 - Width1offset + Width1offset))
		    )
		))
	    (pcLayer = 15)
	    (pcPurpose = "drawing")
	    (pcInst = dbCreateRect(pcCellView
		    list(pcLayer pcPurpose)
		    list(((0.36 + (pcIndexX * pcStepX)):(-20.08 - Width1offset + Width1offset))
			((0.64 + (pcIndexX * pcStepX)):(-19.8 - Width1offset + Width1offset))
		    )
		))
	    (pcLayer = 15)
	    (pcPurpose = "drawing")
	    (pcInst = dbCreateRect(pcCellView
		    list(pcLayer pcPurpose)
		    list(((0.36 + (pcIndexX * pcStepX)):(-19.36 - Width1offset + Width1offset))
			((0.64 + (pcIndexX * pcStepX)):(-19.08 - Width1offset + Width1offset))
		    )
		))
	    (pcLayer = 15)
	    (pcPurpose = "drawing")
	    (pcInst = dbCreateRect(pcCellView
		    list(pcLayer pcPurpose)
		    list(((0.36 + (pcIndexX * pcStepX)):(-18.64 - Width1offset + Width1offset))
			((0.64 + (pcIndexX * pcStepX)):(-18.36 - Width1offset + Width1offset))
		    )
		))
	    (pcLayer = 15)
	    (pcPurpose = "drawing")
	    (pcInst = dbCreateRect(pcCellView
		    list(pcLayer pcPurpose)
		    list(((0.36 + (pcIndexX * pcStepX)):(-17.92 - Width1offset + Width1offset))
			((0.64 + (pcIndexX * pcStepX)):(-17.64 - Width1offset + Width1offset))
		    )
		))
	    (pcLayer = 15)
	    (pcPurpose = "drawing")
	    (pcInst = dbCreateRect(pcCellView
		    list(pcLayer pcPurpose)
		    list(((0.36 + (pcIndexX * pcStepX)):(-17.2 - Width1offset + Width1offset))
			((0.64 + (pcIndexX * pcStepX)):(-16.92 - Width1offset + Width1offset))
		    )
		))
	    (pcLayer = 15)
	    (pcPurpose = "drawing")
	    (pcInst = dbCreateRect(pcCellView
		    list(pcLayer pcPurpose)
		    list(((0.36 + (pcIndexX * pcStepX)):(-16.48 - Width1offset + Width1offset))
			((0.64 + (pcIndexX * pcStepX)):(-16.2 - Width1offset + Width1offset))
		    )
		))
	    (pcLayer = 15)
	    (pcPurpose = "drawing")
	    (pcInst = dbCreateRect(pcCellView
		    list(pcLayer pcPurpose)
		    list(((0.36 + (pcIndexX * pcStepX)):(-15.76 - Width1offset + Width1offset))
			((0.64 + (pcIndexX * pcStepX)):(-15.48 - Width1offset + Width1offset))
		    )
		))
	    (pcLayer = 15)
	    (pcPurpose = "drawing")
	    (pcInst = dbCreateRect(pcCellView
		    list(pcLayer pcPurpose)
		    list(((0.36 + (pcIndexX * pcStepX)):(-15.04 - Width1offset + Width1offset))
			((0.64 + (pcIndexX * pcStepX)):(-14.76 - Width1offset + Width1offset))
		    )
		))
	    (pcLayer = 17)
	    (pcPurpose = "drawing")
	    (pcInst = dbCreateRect(pcCellView
		    list(pcLayer pcPurpose)
		    list(((0.32 + (pcIndexX * pcStepX)):(-20.12 - Width1offset + Width1offset))
			((0.68 + (pcIndexX * pcStepX)):(-19.76 - Width1offset + Width1offset))
		    )
		))
	    (pcLayer = 17)
	    (pcPurpose = "drawing")
	    (pcInst = dbCreateRect(pcCellView
		    list(pcLayer pcPurpose)
		    list(((0.32 + (pcIndexX * pcStepX)):(-19.4 - Width1offset + Width1offset))
			((0.68 + (pcIndexX * pcStepX)):(-19.04 - Width1offset + Width1offset))
		    )
		))
	    (pcLayer = 17)
	    (pcPurpose = "drawing")
	    (pcInst = dbCreateRect(pcCellView
		    list(pcLayer pcPurpose)
		    list(((0.32 + (pcIndexX * pcStepX)):(-18.68 - Width1offset + Width1offset))
			((0.68 + (pcIndexX * pcStepX)):(-18.32 - Width1offset + Width1offset))
		    )
		))
	    (pcLayer = 17)
	    (pcPurpose = "drawing")
	    (pcInst = dbCreateRect(pcCellView
		    list(pcLayer pcPurpose)
		    list(((0.32 + (pcIndexX * pcStepX)):(-17.96 - Width1offset + Width1offset))
			((0.68 + (pcIndexX * pcStepX)):(-17.6 - Width1offset + Width1offset))
		    )
		))
	    (pcLayer = 17)
	    (pcPurpose = "drawing")
	    (pcInst = dbCreateRect(pcCellView
		    list(pcLayer pcPurpose)
		    list(((0.32 + (pcIndexX * pcStepX)):(-17.24 - Width1offset + Width1offset))
			((0.68 + (pcIndexX * pcStepX)):(-16.88 - Width1offset + Width1offset))
		    )
		))
	    (pcLayer = 17)
	    (pcPurpose = "drawing")
	    (pcInst = dbCreateRect(pcCellView
		    list(pcLayer pcPurpose)
		    list(((0.32 + (pcIndexX * pcStepX)):(-16.52 - Width1offset + Width1offset))
			((0.68 + (pcIndexX * pcStepX)):(-16.16 - Width1offset + Width1offset))
		    )
		))
	    (pcLayer = 17)
	    (pcPurpose = "drawing")
	    (pcInst = dbCreateRect(pcCellView
		    list(pcLayer pcPurpose)
		    list(((0.32 + (pcIndexX * pcStepX)):(-15.8 - Width1offset + Width1offset))
			((0.68 + (pcIndexX * pcStepX)):(-15.44 - Width1offset + Width1offset))
		    )
		))
	    (pcLayer = 17)
	    (pcPurpose = "drawing")
	    (pcInst = dbCreateRect(pcCellView
		    list(pcLayer pcPurpose)
		    list(((0.32 + (pcIndexX * pcStepX)):(-15.08 - Width1offset + Width1offset))
			((0.68 + (pcIndexX * pcStepX)):(-14.72 - Width1offset + Width1offset))
		    )
		))
	)
	(pcRepeat = (pcRepeatX = (pcRepeatY = 1.0)))
	(pcStep = (pcStepX = (pcStepY = 0.0)))
	(pcStep = (pcStepX = car(errset(0.64))))
	(pcRepeat = (pcRepeatX = fix(((Length - 0.36) / pcStep))))
	(pcStep = (pcStepX = 0.64))
	(pcIndexY = 0)
	for(pcIndexX 0
	    (fix(pcRepeatX) - 1) nil
	    (pcLayer = 11)
	    (pcPurpose = "drawing")
	    (pcInst = dbCreateRect(pcCellView
		    list(pcLayer pcPurpose)
		    list(((0.36 + (pcIndexX * pcStepX)):(12.74 + Width1offset - Width1offset))
			((0.64 + (pcIndexX * pcStepX)):(13.02 + Width1offset - Width1offset))
		    )
		))
	    (pcLayer = 11)
	    (pcPurpose = "drawing")
	    (pcInst = dbCreateRect(pcCellView
		    list(pcLayer pcPurpose)
		    list(((0.36 + (pcIndexX * pcStepX)):(12.18 + Width1offset - Width1offset))
			((0.64 + (pcIndexX * pcStepX)):(12.46 + Width1offset - Width1offset))
		    )
		))
	    (pcLayer = 11)
	    (pcPurpose = "drawing")
	    (pcInst = dbCreateRect(pcCellView
		    list(pcLayer pcPurpose)
		    list(((0.36 + (pcIndexX * pcStepX)):(-12.46 - Width1offset + Width1offset))
			((0.64 + (pcIndexX * pcStepX)):(-12.18 - Width1offset + Width1offset))
		    )
		))
	    (pcLayer = 11)
	    (pcPurpose = "drawing")
	    (pcInst = dbCreateRect(pcCellView
		    list(pcLayer pcPurpose)
		    list(((0.36 + (pcIndexX * pcStepX)):(-13.02 - Width1offset + Width1offset))
			((0.64 + (pcIndexX * pcStepX)):(-12.74 - Width1offset + Width1offset))
		    )
		))
	)
	(pcLayer = 12)
	(pcPurpose = "drawing")
	(pcInst = dbCreateRect(pcCellView
		list(pcLayer pcPurpose)
		list((0.0:(12.0 + Width1offset - Width1offset))
		    ((1.0 + Length0offset):(20.5 + Width1offset - Width1offset))
		)
	    ))
	(pcLayer = 12)
	(pcPurpose = "drawing")
	(pcInst = dbCreateRect(pcCellView
		list(pcLayer pcPurpose)
		list((0.0:(-20.5 - Width1offset + Width1offset))
		    ((1.0 + Length0offset):(-12.0 - Width1offset + Width1offset))
		)
	    ))
	(pcLayer = 14)
	(pcPurpose = "drawing")
	(pcInst = dbCreateRect(pcCellView
		list(pcLayer pcPurpose)
		list((0.0:(14.4 + Width1offset - Width1offset))
		    ((1.0 + Length0offset):(20.5 + Width1offset - Width1offset))
		)
	    ))
	(pcLayer = 14)
	(pcPurpose = "drawing")
	(pcInst = dbCreateRect(pcCellView
		list(pcLayer pcPurpose)
		list((0.0:(-20.5 - Width1offset + Width1offset))
		    ((1.0 + Length0offset):(-14.4 - Width1offset + Width1offset))
		)
	    ))
	(pcLayer = 16)
	(pcPurpose = "drawing")
	(pcInst = dbCreateRect(pcCellView
		list(pcLayer pcPurpose)
		list((0.0:(-20.5 - Width1offset + Width1offset))
		    ((1.0 + Length0offset):(-14.4 - Width1offset + Width1offset))
		)
	    ))
	(pcLayer = 16)
	(pcPurpose = "drawing")
	(pcInst = dbCreateRect(pcCellView
		list(pcLayer pcPurpose)
		list((0.0:(14.4 + Width1offset - Width1offset))
		    ((1.0 + Length0offset):(20.5 + Width1offset - Width1offset))
		)
	    ))
	(pcLayer = 18)
	(pcPurpose = "drawing")
	(pcInst = dbCreateRect(pcCellView
		list(pcLayer pcPurpose)
		list((0.0:(-4.0 - Width1offset))
		    ((1.0 + Length0offset):(4.0 + Width1offset))
		)
	    ))
	(pcLayer = 18)
	(pcPurpose = "drawing")
	(pcInst = dbCreateRect(pcCellView
		list(pcLayer pcPurpose)
		list((0.0:(-20.5 - Width1offset + Width1offset))
		    ((1.0 + Length0offset):(-14.4 - Width1offset + Width1offset))
		)
	    ))
	(pcLayer = 18)
	(pcPurpose = "drawing")
	(pcInst = dbCreateRect(pcCellView
		list(pcLayer pcPurpose)
		list((0.0:(14.4 + Width1offset - Width1offset))
		    ((1.0 + Length0offset):(20.5 + Width1offset - Width1offset))
		)
	    ))
	(pcLayer = 10)
	(pcPurpose = "drawing")
	(pcInst = dbCreateRect(pcCellView
		list(pcLayer pcPurpose)
		list((0.0:(14.4 + Width1offset - Width1offset))
		    ((1.0 + Length0offset):(20.5 + Width1offset - Width1offset))
		)
	    ))
	(pcLayer = 10)
	(pcPurpose = "drawing")
	(pcInst = dbCreateRect(pcCellView
		list(pcLayer pcPurpose)
		list((0.0:(-13.3 - Width1offset + Width1offset))
		    ((1.0 + Length0offset):(13.3 + Width1offset - Width1offset))
		)
	    ))
	(pcLayer = 10)
	(pcPurpose = "drawing")
	(pcInst = dbCreateRect(pcCellView
		list(pcLayer pcPurpose)
		list((0.0:(-20.5 - Width1offset + Width1offset))
		    ((1.0 + Length0offset):(-14.4 - Width1offset + Width1offset))
		)
	    ))
	(pcLayer = 28)
	(pcPurpose = "drawing")
	(pcInst = dbCreateRect(pcCellView
		list(pcLayer pcPurpose)
		list((0.0:(-14.4 - Width1offset + Width1offset))
		    ((1.0 + Length0offset):(14.4 + Width1offset - Width1offset))
		)
	    )) t
    )
)
