pcDefinePCell(list(ddGetObj("ROHMLIB") "TLINE_DIFF" "layout")
    ((Length float 1.0))
    let((Length Length0 Length0offset pcMember pcStretchGroup
	    stretchOffsetX stretchOffsetY pcLib pcMaster pcInst
	    pcTerm pcPin pcPinName pcNet pcTermNet
	    pcNetName pcTermNetName pcMosaicInst pcParameters pcParamProp
	    pcStep pcStepX pcStepY pcRepeat pcRepeatX
	    pcRepeatY pcIndexX pcIndexY pcLayer pcPurpose
	    pcLabelText pcLabelHeight pcPropText pcParamText pcCoords
	    pcPathWidth pcPolygonMargin
	)
	(pcLib = (pcCellView~>lib))
	(pcParameters = ((pcCellView~>parameters)~>value))
	(pcParamProp = car(exists(prop pcParameters
		    ((prop~>name) == "Length")
		)
	    ))
	(Length = (pcParamProp~>value))
	if(((pcParamProp~>valueType) == "boolean")
	    (Length = (Length == "TRUE"))
	)
	(Length0 = Length)
	if((Length0 < 1) then
	    (Length0 = 1.0)
	)
	(Length0offset = (Length0 - 1))
	dbReplaceProp(pcCellView "_pcCompiledCounter" "int" 1497)
	dbReplaceProp(pcCellView "viewSubType" "string" "maskLayoutParamCell")
	(pcRepeat = (pcRepeatX = (pcRepeatY = 1.0)))
	(pcStep = (pcStepX = (pcStepY = 0.0)))
	(pcStep = (pcStepX = car(errset(0.72))))
	(pcRepeat = (pcRepeatX = fix(((Length - 0.32) / pcStep))))
	(pcStep = (pcStepX = 0.72))
	(pcIndexY = 0)
	for(pcIndexX 0
	    (fix(pcRepeatX) - 1) nil
	    (pcLayer = 11)
	    (pcPurpose = "drawing")
	    (pcInst = dbCreateRect(pcCellView
		    list(pcLayer pcPurpose)
		    list(((0.36 + (pcIndexX * pcStepX)):20.26)
			((0.64 + (pcIndexX * pcStepX)):20.54)
		    )
		))
	    (pcLayer = 11)
	    (pcPurpose = "drawing")
	    (pcInst = dbCreateRect(pcCellView
		    list(pcLayer pcPurpose)
		    list(((0.36 + (pcIndexX * pcStepX)):20.98)
			((0.64 + (pcIndexX * pcStepX)):21.26)
		    )
		))
	    (pcLayer = 11)
	    (pcPurpose = "drawing")
	    (pcInst = dbCreateRect(pcCellView
		    list(pcLayer pcPurpose)
		    list(((0.36 + (pcIndexX * pcStepX)):25.3)
			((0.64 + (pcIndexX * pcStepX)):25.58)
		    )
		))
	    (pcLayer = 11)
	    (pcPurpose = "drawing")
	    (pcInst = dbCreateRect(pcCellView
		    list(pcLayer pcPurpose)
		    list(((0.36 + (pcIndexX * pcStepX)):24.58)
			((0.64 + (pcIndexX * pcStepX)):24.86)
		    )
		))
	    (pcLayer = 11)
	    (pcPurpose = "drawing")
	    (pcInst = dbCreateRect(pcCellView
		    list(pcLayer pcPurpose)
		    list(((0.36 + (pcIndexX * pcStepX)):23.86)
			((0.64 + (pcIndexX * pcStepX)):24.14)
		    )
		))
	    (pcLayer = 11)
	    (pcPurpose = "drawing")
	    (pcInst = dbCreateRect(pcCellView
		    list(pcLayer pcPurpose)
		    list(((0.36 + (pcIndexX * pcStepX)):23.14)
			((0.64 + (pcIndexX * pcStepX)):23.42)
		    )
		))
	    (pcLayer = 11)
	    (pcPurpose = "drawing")
	    (pcInst = dbCreateRect(pcCellView
		    list(pcLayer pcPurpose)
		    list(((0.36 + (pcIndexX * pcStepX)):22.42)
			((0.64 + (pcIndexX * pcStepX)):22.7)
		    )
		))
	    (pcLayer = 11)
	    (pcPurpose = "drawing")
	    (pcInst = dbCreateRect(pcCellView
		    list(pcLayer pcPurpose)
		    list(((0.36 + (pcIndexX * pcStepX)):21.7)
			((0.64 + (pcIndexX * pcStepX)):21.98)
		    )
		))
	    (pcLayer = 13)
	    (pcPurpose = "drawing")
	    (pcInst = dbCreateRect(pcCellView
		    list(pcLayer pcPurpose)
		    list(((0.36 + (pcIndexX * pcStepX)):20.98)
			((0.64 + (pcIndexX * pcStepX)):21.26)
		    )
		))
	    (pcLayer = 13)
	    (pcPurpose = "drawing")
	    (pcInst = dbCreateRect(pcCellView
		    list(pcLayer pcPurpose)
		    list(((0.36 + (pcIndexX * pcStepX)):20.26)
			((0.64 + (pcIndexX * pcStepX)):20.54)
		    )
		))
	    (pcLayer = 13)
	    (pcPurpose = "drawing")
	    (pcInst = dbCreateRect(pcCellView
		    list(pcLayer pcPurpose)
		    list(((0.36 + (pcIndexX * pcStepX)):21.7)
			((0.64 + (pcIndexX * pcStepX)):21.98)
		    )
		))
	    (pcLayer = 13)
	    (pcPurpose = "drawing")
	    (pcInst = dbCreateRect(pcCellView
		    list(pcLayer pcPurpose)
		    list(((0.36 + (pcIndexX * pcStepX)):22.42)
			((0.64 + (pcIndexX * pcStepX)):22.7)
		    )
		))
	    (pcLayer = 13)
	    (pcPurpose = "drawing")
	    (pcInst = dbCreateRect(pcCellView
		    list(pcLayer pcPurpose)
		    list(((0.36 + (pcIndexX * pcStepX)):23.14)
			((0.64 + (pcIndexX * pcStepX)):23.42)
		    )
		))
	    (pcLayer = 13)
	    (pcPurpose = "drawing")
	    (pcInst = dbCreateRect(pcCellView
		    list(pcLayer pcPurpose)
		    list(((0.36 + (pcIndexX * pcStepX)):23.86)
			((0.64 + (pcIndexX * pcStepX)):24.14)
		    )
		))
	    (pcLayer = 13)
	    (pcPurpose = "drawing")
	    (pcInst = dbCreateRect(pcCellView
		    list(pcLayer pcPurpose)
		    list(((0.36 + (pcIndexX * pcStepX)):24.58)
			((0.64 + (pcIndexX * pcStepX)):24.86)
		    )
		))
	    (pcLayer = 13)
	    (pcPurpose = "drawing")
	    (pcInst = dbCreateRect(pcCellView
		    list(pcLayer pcPurpose)
		    list(((0.36 + (pcIndexX * pcStepX)):25.3)
			((0.64 + (pcIndexX * pcStepX)):25.58)
		    )
		))
	    (pcLayer = 15)
	    (pcPurpose = "drawing")
	    (pcInst = dbCreateRect(pcCellView
		    list(pcLayer pcPurpose)
		    list(((0.36 + (pcIndexX * pcStepX)):20.26)
			((0.64 + (pcIndexX * pcStepX)):20.54)
		    )
		))
	    (pcLayer = 15)
	    (pcPurpose = "drawing")
	    (pcInst = dbCreateRect(pcCellView
		    list(pcLayer pcPurpose)
		    list(((0.36 + (pcIndexX * pcStepX)):20.98)
			((0.64 + (pcIndexX * pcStepX)):21.26)
		    )
		))
	    (pcLayer = 15)
	    (pcPurpose = "drawing")
	    (pcInst = dbCreateRect(pcCellView
		    list(pcLayer pcPurpose)
		    list(((0.36 + (pcIndexX * pcStepX)):21.7)
			((0.64 + (pcIndexX * pcStepX)):21.98)
		    )
		))
	    (pcLayer = 15)
	    (pcPurpose = "drawing")
	    (pcInst = dbCreateRect(pcCellView
		    list(pcLayer pcPurpose)
		    list(((0.36 + (pcIndexX * pcStepX)):22.42)
			((0.64 + (pcIndexX * pcStepX)):22.7)
		    )
		))
	    (pcLayer = 15)
	    (pcPurpose = "drawing")
	    (pcInst = dbCreateRect(pcCellView
		    list(pcLayer pcPurpose)
		    list(((0.36 + (pcIndexX * pcStepX)):23.14)
			((0.64 + (pcIndexX * pcStepX)):23.42)
		    )
		))
	    (pcLayer = 15)
	    (pcPurpose = "drawing")
	    (pcInst = dbCreateRect(pcCellView
		    list(pcLayer pcPurpose)
		    list(((0.36 + (pcIndexX * pcStepX)):23.86)
			((0.64 + (pcIndexX * pcStepX)):24.14)
		    )
		))
	    (pcLayer = 15)
	    (pcPurpose = "drawing")
	    (pcInst = dbCreateRect(pcCellView
		    list(pcLayer pcPurpose)
		    list(((0.36 + (pcIndexX * pcStepX)):24.58)
			((0.64 + (pcIndexX * pcStepX)):24.86)
		    )
		))
	    (pcLayer = 15)
	    (pcPurpose = "drawing")
	    (pcInst = dbCreateRect(pcCellView
		    list(pcLayer pcPurpose)
		    list(((0.36 + (pcIndexX * pcStepX)):25.3)
			((0.64 + (pcIndexX * pcStepX)):25.58)
		    )
		))
	    (pcLayer = 17)
	    (pcPurpose = "drawing")
	    (pcInst = dbCreateRect(pcCellView
		    list(pcLayer pcPurpose)
		    list(((0.32 + (pcIndexX * pcStepX)):20.22)
			((0.68 + (pcIndexX * pcStepX)):20.58)
		    )
		))
	    (pcLayer = 17)
	    (pcPurpose = "drawing")
	    (pcInst = dbCreateRect(pcCellView
		    list(pcLayer pcPurpose)
		    list(((0.32 + (pcIndexX * pcStepX)):20.94)
			((0.68 + (pcIndexX * pcStepX)):21.3)
		    )
		))
	    (pcLayer = 17)
	    (pcPurpose = "drawing")
	    (pcInst = dbCreateRect(pcCellView
		    list(pcLayer pcPurpose)
		    list(((0.32 + (pcIndexX * pcStepX)):21.66)
			((0.68 + (pcIndexX * pcStepX)):22.02)
		    )
		))
	    (pcLayer = 17)
	    (pcPurpose = "drawing")
	    (pcInst = dbCreateRect(pcCellView
		    list(pcLayer pcPurpose)
		    list(((0.32 + (pcIndexX * pcStepX)):22.38)
			((0.68 + (pcIndexX * pcStepX)):22.74)
		    )
		))
	    (pcLayer = 17)
	    (pcPurpose = "drawing")
	    (pcInst = dbCreateRect(pcCellView
		    list(pcLayer pcPurpose)
		    list(((0.32 + (pcIndexX * pcStepX)):23.1)
			((0.68 + (pcIndexX * pcStepX)):23.46)
		    )
		))
	    (pcLayer = 17)
	    (pcPurpose = "drawing")
	    (pcInst = dbCreateRect(pcCellView
		    list(pcLayer pcPurpose)
		    list(((0.32 + (pcIndexX * pcStepX)):23.82)
			((0.68 + (pcIndexX * pcStepX)):24.18)
		    )
		))
	    (pcLayer = 17)
	    (pcPurpose = "drawing")
	    (pcInst = dbCreateRect(pcCellView
		    list(pcLayer pcPurpose)
		    list(((0.32 + (pcIndexX * pcStepX)):24.54)
			((0.68 + (pcIndexX * pcStepX)):24.9)
		    )
		))
	    (pcLayer = 17)
	    (pcPurpose = "drawing")
	    (pcInst = dbCreateRect(pcCellView
		    list(pcLayer pcPurpose)
		    list(((0.32 + (pcIndexX * pcStepX)):25.26)
			((0.68 + (pcIndexX * pcStepX)):25.62)
		    )
		))
	    (pcLayer = 11)
	    (pcPurpose = "drawing")
	    (pcInst = dbCreateRect(pcCellView
		    list(pcLayer pcPurpose)
		    list(((0.36 + (pcIndexX * pcStepX)):18.24)
			((0.64 + (pcIndexX * pcStepX)):18.52)
		    )
		))
	    (pcLayer = 11)
	    (pcPurpose = "drawing")
	    (pcInst = dbCreateRect(pcCellView
		    list(pcLayer pcPurpose)
		    list(((0.36 + (pcIndexX * pcStepX)):17.68)
			((0.64 + (pcIndexX * pcStepX)):17.96)
		    )
		))
	    (pcLayer = 11)
	    (pcPurpose = "drawing")
	    (pcInst = dbCreateRect(pcCellView
		    list(pcLayer pcPurpose)
		    list(((0.46 + (pcIndexX * pcStepX)):1.02)
			((0.74 + (pcIndexX * pcStepX)):1.3)
		    )
		))
	    (pcLayer = 11)
	    (pcPurpose = "drawing")
	    (pcInst = dbCreateRect(pcCellView
		    list(pcLayer pcPurpose)
		    list(((0.46 + (pcIndexX * pcStepX)):-1.3)
			((0.74 + (pcIndexX * pcStepX)):-1.02)
		    )
		))
	    (pcLayer = 11)
	    (pcPurpose = "drawing")
	    (pcInst = dbCreateRect(pcCellView
		    list(pcLayer pcPurpose)
		    list(((0.36 + (pcIndexX * pcStepX)):-17.96)
			((0.64 + (pcIndexX * pcStepX)):-17.68)
		    )
		))
	    (pcLayer = 11)
	    (pcPurpose = "drawing")
	    (pcInst = dbCreateRect(pcCellView
		    list(pcLayer pcPurpose)
		    list(((0.36 + (pcIndexX * pcStepX)):-18.52)
			((0.64 + (pcIndexX * pcStepX)):-18.24)
		    )
		))
	    (pcLayer = 11)
	    (pcPurpose = "drawing")
	    (pcInst = dbCreateRect(pcCellView
		    list(pcLayer pcPurpose)
		    list(((0.36 + (pcIndexX * pcStepX)):-20.54)
			((0.64 + (pcIndexX * pcStepX)):-20.26)
		    )
		))
	    (pcLayer = 11)
	    (pcPurpose = "drawing")
	    (pcInst = dbCreateRect(pcCellView
		    list(pcLayer pcPurpose)
		    list(((0.36 + (pcIndexX * pcStepX)):-21.26)
			((0.64 + (pcIndexX * pcStepX)):-20.98)
		    )
		))
	    (pcLayer = 11)
	    (pcPurpose = "drawing")
	    (pcInst = dbCreateRect(pcCellView
		    list(pcLayer pcPurpose)
		    list(((0.36 + (pcIndexX * pcStepX)):-21.98)
			((0.64 + (pcIndexX * pcStepX)):-21.7)
		    )
		))
	    (pcLayer = 11)
	    (pcPurpose = "drawing")
	    (pcInst = dbCreateRect(pcCellView
		    list(pcLayer pcPurpose)
		    list(((0.36 + (pcIndexX * pcStepX)):-22.7)
			((0.64 + (pcIndexX * pcStepX)):-22.42)
		    )
		))
	    (pcLayer = 11)
	    (pcPurpose = "drawing")
	    (pcInst = dbCreateRect(pcCellView
		    list(pcLayer pcPurpose)
		    list(((0.36 + (pcIndexX * pcStepX)):-23.42)
			((0.64 + (pcIndexX * pcStepX)):-23.14)
		    )
		))
	    (pcLayer = 11)
	    (pcPurpose = "drawing")
	    (pcInst = dbCreateRect(pcCellView
		    list(pcLayer pcPurpose)
		    list(((0.36 + (pcIndexX * pcStepX)):-24.14)
			((0.64 + (pcIndexX * pcStepX)):-23.86)
		    )
		))
	    (pcLayer = 11)
	    (pcPurpose = "drawing")
	    (pcInst = dbCreateRect(pcCellView
		    list(pcLayer pcPurpose)
		    list(((0.36 + (pcIndexX * pcStepX)):-24.86)
			((0.64 + (pcIndexX * pcStepX)):-24.58)
		    )
		))
	    (pcLayer = 11)
	    (pcPurpose = "drawing")
	    (pcInst = dbCreateRect(pcCellView
		    list(pcLayer pcPurpose)
		    list(((0.36 + (pcIndexX * pcStepX)):-25.58)
			((0.64 + (pcIndexX * pcStepX)):-25.3)
		    )
		))
	    (pcLayer = 13)
	    (pcPurpose = "drawing")
	    (pcInst = dbCreateRect(pcCellView
		    list(pcLayer pcPurpose)
		    list(((0.36 + (pcIndexX * pcStepX)):-21.26)
			((0.64 + (pcIndexX * pcStepX)):-20.98)
		    )
		))
	    (pcLayer = 13)
	    (pcPurpose = "drawing")
	    (pcInst = dbCreateRect(pcCellView
		    list(pcLayer pcPurpose)
		    list(((0.36 + (pcIndexX * pcStepX)):-20.54)
			((0.64 + (pcIndexX * pcStepX)):-20.26)
		    )
		))
	    (pcLayer = 13)
	    (pcPurpose = "drawing")
	    (pcInst = dbCreateRect(pcCellView
		    list(pcLayer pcPurpose)
		    list(((0.36 + (pcIndexX * pcStepX)):-21.98)
			((0.64 + (pcIndexX * pcStepX)):-21.7)
		    )
		))
	    (pcLayer = 13)
	    (pcPurpose = "drawing")
	    (pcInst = dbCreateRect(pcCellView
		    list(pcLayer pcPurpose)
		    list(((0.36 + (pcIndexX * pcStepX)):-22.7)
			((0.64 + (pcIndexX * pcStepX)):-22.42)
		    )
		))
	    (pcLayer = 13)
	    (pcPurpose = "drawing")
	    (pcInst = dbCreateRect(pcCellView
		    list(pcLayer pcPurpose)
		    list(((0.36 + (pcIndexX * pcStepX)):-23.42)
			((0.64 + (pcIndexX * pcStepX)):-23.14)
		    )
		))
	    (pcLayer = 13)
	    (pcPurpose = "drawing")
	    (pcInst = dbCreateRect(pcCellView
		    list(pcLayer pcPurpose)
		    list(((0.36 + (pcIndexX * pcStepX)):-24.14)
			((0.64 + (pcIndexX * pcStepX)):-23.86)
		    )
		))
	    (pcLayer = 13)
	    (pcPurpose = "drawing")
	    (pcInst = dbCreateRect(pcCellView
		    list(pcLayer pcPurpose)
		    list(((0.36 + (pcIndexX * pcStepX)):-24.86)
			((0.64 + (pcIndexX * pcStepX)):-24.58)
		    )
		))
	    (pcLayer = 13)
	    (pcPurpose = "drawing")
	    (pcInst = dbCreateRect(pcCellView
		    list(pcLayer pcPurpose)
		    list(((0.36 + (pcIndexX * pcStepX)):-25.58)
			((0.64 + (pcIndexX * pcStepX)):-25.3)
		    )
		))
	    (pcLayer = 15)
	    (pcPurpose = "drawing")
	    (pcInst = dbCreateRect(pcCellView
		    list(pcLayer pcPurpose)
		    list(((0.36 + (pcIndexX * pcStepX)):-20.54)
			((0.64 + (pcIndexX * pcStepX)):-20.26)
		    )
		))
	    (pcLayer = 15)
	    (pcPurpose = "drawing")
	    (pcInst = dbCreateRect(pcCellView
		    list(pcLayer pcPurpose)
		    list(((0.36 + (pcIndexX * pcStepX)):-21.26)
			((0.64 + (pcIndexX * pcStepX)):-20.98)
		    )
		))
	    (pcLayer = 15)
	    (pcPurpose = "drawing")
	    (pcInst = dbCreateRect(pcCellView
		    list(pcLayer pcPurpose)
		    list(((0.36 + (pcIndexX * pcStepX)):-21.98)
			((0.64 + (pcIndexX * pcStepX)):-21.7)
		    )
		))
	    (pcLayer = 15)
	    (pcPurpose = "drawing")
	    (pcInst = dbCreateRect(pcCellView
		    list(pcLayer pcPurpose)
		    list(((0.36 + (pcIndexX * pcStepX)):-22.7)
			((0.64 + (pcIndexX * pcStepX)):-22.42)
		    )
		))
	    (pcLayer = 15)
	    (pcPurpose = "drawing")
	    (pcInst = dbCreateRect(pcCellView
		    list(pcLayer pcPurpose)
		    list(((0.36 + (pcIndexX * pcStepX)):-23.42)
			((0.64 + (pcIndexX * pcStepX)):-23.14)
		    )
		))
	    (pcLayer = 15)
	    (pcPurpose = "drawing")
	    (pcInst = dbCreateRect(pcCellView
		    list(pcLayer pcPurpose)
		    list(((0.36 + (pcIndexX * pcStepX)):-24.14)
			((0.64 + (pcIndexX * pcStepX)):-23.86)
		    )
		))
	    (pcLayer = 15)
	    (pcPurpose = "drawing")
	    (pcInst = dbCreateRect(pcCellView
		    list(pcLayer pcPurpose)
		    list(((0.36 + (pcIndexX * pcStepX)):-24.86)
			((0.64 + (pcIndexX * pcStepX)):-24.58)
		    )
		))
	    (pcLayer = 15)
	    (pcPurpose = "drawing")
	    (pcInst = dbCreateRect(pcCellView
		    list(pcLayer pcPurpose)
		    list(((0.36 + (pcIndexX * pcStepX)):-25.58)
			((0.64 + (pcIndexX * pcStepX)):-25.3)
		    )
		))
	    (pcLayer = 17)
	    (pcPurpose = "drawing")
	    (pcInst = dbCreateRect(pcCellView
		    list(pcLayer pcPurpose)
		    list(((0.32 + (pcIndexX * pcStepX)):-20.58)
			((0.68 + (pcIndexX * pcStepX)):-20.22)
		    )
		))
	    (pcLayer = 17)
	    (pcPurpose = "drawing")
	    (pcInst = dbCreateRect(pcCellView
		    list(pcLayer pcPurpose)
		    list(((0.32 + (pcIndexX * pcStepX)):-21.3)
			((0.68 + (pcIndexX * pcStepX)):-20.94)
		    )
		))
	    (pcLayer = 17)
	    (pcPurpose = "drawing")
	    (pcInst = dbCreateRect(pcCellView
		    list(pcLayer pcPurpose)
		    list(((0.32 + (pcIndexX * pcStepX)):-22.02)
			((0.68 + (pcIndexX * pcStepX)):-21.66)
		    )
		))
	    (pcLayer = 17)
	    (pcPurpose = "drawing")
	    (pcInst = dbCreateRect(pcCellView
		    list(pcLayer pcPurpose)
		    list(((0.32 + (pcIndexX * pcStepX)):-22.74)
			((0.68 + (pcIndexX * pcStepX)):-22.38)
		    )
		))
	    (pcLayer = 17)
	    (pcPurpose = "drawing")
	    (pcInst = dbCreateRect(pcCellView
		    list(pcLayer pcPurpose)
		    list(((0.32 + (pcIndexX * pcStepX)):-23.46)
			((0.68 + (pcIndexX * pcStepX)):-23.1)
		    )
		))
	    (pcLayer = 17)
	    (pcPurpose = "drawing")
	    (pcInst = dbCreateRect(pcCellView
		    list(pcLayer pcPurpose)
		    list(((0.32 + (pcIndexX * pcStepX)):-24.18)
			((0.68 + (pcIndexX * pcStepX)):-23.82)
		    )
		))
	    (pcLayer = 17)
	    (pcPurpose = "drawing")
	    (pcInst = dbCreateRect(pcCellView
		    list(pcLayer pcPurpose)
		    list(((0.32 + (pcIndexX * pcStepX)):-24.9)
			((0.68 + (pcIndexX * pcStepX)):-24.54)
		    )
		))
	    (pcLayer = 17)
	    (pcPurpose = "drawing")
	    (pcInst = dbCreateRect(pcCellView
		    list(pcLayer pcPurpose)
		    list(((0.32 + (pcIndexX * pcStepX)):-25.62)
			((0.68 + (pcIndexX * pcStepX)):-25.26)
		    )
		))
	)
	(pcLayer = 12)
	(pcPurpose = "drawing")
	(pcInst = dbCreateRect(pcCellView
		list(pcLayer pcPurpose)
		list((0.0:-26.0)
		    ((1.0 + Length0offset):-19.9)
		)
	    ))
	(pcLayer = 12)
	(pcPurpose = "drawing")
	(pcInst = dbCreateRect(pcCellView
		list(pcLayer pcPurpose)
		list((0.0:-1.76)
		    ((1.0 + Length0offset):1.76)
		)
	    ))
	(pcLayer = 12)
	(pcPurpose = "drawing")
	(pcInst = dbCreateRect(pcCellView
		list(pcLayer pcPurpose)
		list((0.0:19.9)
		    ((1.0 + Length0offset):26.0)
		)
	    ))
	(pcLayer = 12)
	(pcPurpose = "drawing")
	(pcInst = dbCreateRect(pcCellView
		list(pcLayer pcPurpose)
		list((0.0:17.5)
		    ((1.0 + Length0offset):19.9)
		)
	    ))
	(pcLayer = 12)
	(pcPurpose = "drawing")
	(pcInst = dbCreateRect(pcCellView
		list(pcLayer pcPurpose)
		list((0.0:-19.9)
		    ((1.0 + Length0offset):-17.5)
		)
	    ))
	(pcLayer = 14)
	(pcPurpose = "drawing")
	(pcInst = dbCreateRect(pcCellView
		list(pcLayer pcPurpose)
		list((0.0:-26.0)
		    ((1.0 + Length0offset):-19.9)
		)
	    ))
	(pcLayer = 14)
	(pcPurpose = "drawing")
	(pcInst = dbCreateRect(pcCellView
		list(pcLayer pcPurpose)
		list((0.0:19.9)
		    ((1.0 + Length0offset):26.0)
		)
	    ))
	(pcLayer = 16)
	(pcPurpose = "drawing")
	(pcInst = dbCreateRect(pcCellView
		list(pcLayer pcPurpose)
		list((0.0:-26.0)
		    ((1.0 + Length0offset):-19.9)
		)
	    ))
	(pcLayer = 16)
	(pcPurpose = "drawing")
	(pcInst = dbCreateRect(pcCellView
		list(pcLayer pcPurpose)
		list((0.0:19.9)
		    ((1.0 + Length0offset):26.0)
		)
	    ))
	(pcLayer = 18)
	(pcPurpose = "drawing")
	(pcInst = dbCreateRect(pcCellView
		list(pcLayer pcPurpose)
		list((0.0:-26.0)
		    ((1.0 + Length0offset):-19.9)
		)
	    ))
	(pcLayer = 18)
	(pcPurpose = "drawing")
	(pcInst = dbCreateRect(pcCellView
		list(pcLayer pcPurpose)
		list((0.0:4.5)
		    ((1.0 + Length0offset):10.9)
		)
	    ))
	(pcLayer = 18)
	(pcPurpose = "drawing")
	(pcInst = dbCreateRect(pcCellView
		list(pcLayer pcPurpose)
		list((0.0:-10.9)
		    ((1.0 + Length0offset):-4.5)
		)
	    ))
	(pcLayer = 18)
	(pcPurpose = "drawing")
	(pcInst = dbCreateRect(pcCellView
		list(pcLayer pcPurpose)
		list((0.0:19.9)
		    ((1.0 + Length0offset):26.0)
		)
	    ))
	(pcLayer = 11)
	(pcPurpose = "drawing")
	(pcInst = dbCreateRect(pcCellView
		list(pcLayer pcPurpose)
		list((0.36:-17.96)
		    (0.64:-17.68)
		)
	    ))
	(pcLayer = 10)
	(pcPurpose = "drawing")
	(pcInst = dbCreateRect(pcCellView
		list(pcLayer pcPurpose)
		list((0.0:-26.0)
		    ((1.0 + Length0offset):-19.9)
		)
	    ))
	(pcLayer = 10)
	(pcPurpose = "drawing")
	(pcInst = dbCreateRect(pcCellView
		list(pcLayer pcPurpose)
		list((0.0:-18.8)
		    ((1.0 + Length0offset):-0.5600000000000001)
		)
	    ))
	(pcLayer = 10)
	(pcPurpose = "drawing")
	(pcInst = dbCreateRect(pcCellView
		list(pcLayer pcPurpose)
		list((0.0:19.9)
		    ((1.0 + Length0offset):26.0)
		)
	    ))
	(pcLayer = 10)
	(pcPurpose = "drawing")
	(pcInst = dbCreateRect(pcCellView
		list(pcLayer pcPurpose)
		list((0.0:0.5600000000000001)
		    ((1.0 + Length0offset):18.8)
		)
	    ))
	(pcLayer = 28)
	(pcPurpose = "drawing")
	(pcInst = dbCreateRect(pcCellView
		list(pcLayer pcPurpose)
		list((0.0:-19.9)
		    ((1.0 + Length0offset):19.9)
		)
	    ))
	t
    )
)
